# Ansys Electronics Desktop project, version 2019.2
materials:
  -
  air: permittivity=1.0006
  copper: permeability=0.999991 conductivity=58000000
  duroid: permittivity=2.2 dielectric_loss_tangent=0.001
  FR4
  FR4_epoxy: permittivity=4.4 dielectric_loss_tangent=0.02
  pec: conductivity=1e+30
  Rogers RO4003 (tm): permittivity=3.55 dielectric_loss_tangent=0.0027
  Rogers RO4350 (tm): permittivity=3.66 dielectric_loss_tangent=0.004
  vacuum: permittivity=1

design RF Track Simulation (HFSS 3D Layout)
variables:
  C = 0.5mm  # tune 0.3mm..0.9mm
  D = 0.2mm  # tune 0.15mm..0.45mm
  A = 5mm
components:
  U1508 = RLC_Series(EMInstanceName=RLC_Series:1508 EnableL=false R=0ohm EnableR=true EnableC=false)
  U1509 = RLC_Series(EMInstanceName=RLC_Series:1509 EnableL=false EnableC=false R=0ohm EnableR=true)
  U1510 = RLC_Series(EMInstanceName=RLC_Series:1510 EnableL=false R=0ohm EnableR=true EnableC=false)
  U1511 = RLC_Series(EMInstanceName=RLC_Series:1511 EnableL=false EnableC=false R=0ohm)
  U1512 = RLC_Series(EMInstanceName=RLC_Series:1512 EnableC=false EnableL=false R=0ohm)
  U1513 = RLC_Series(EMInstanceName=RLC_Series:1513 EnableL=false R=0ohm EnableR=true EnableC=false)
  U1514 = RLC_Series(EMInstanceName=RLC_Series:1514 EnableL=false EnableC=false R=0ohm)
  U1515 = RLC_Series(EMInstanceName=RLC_Series:1515 R=0ohm EnableR=true EnableL=false EnableC=false)
  U1516 = RLC_Series(EMInstanceName=RLC_Series:1516 EnableL=false EnableC=false R=0ohm)
  U1517 = RLC_Series(EMInstanceName=RLC_Series:1517 EnableL=false R=0ohm EnableR=true EnableC=false)
  U1518 = RLC_Series(EMInstanceName=RLC_Series:1518 EnableL=false EnableC=false R=0ohm)
  U1519 = RLC_Series(EMInstanceName=RLC_Series:1519 EnableL=false R=0ohm EnableR=true EnableC=false)
  U1520 = RLC_Series(EMInstanceName=RLC_Series:1520 EnableC=false EnableL=false R=0ohm)
  U1521 = RLC_Series(EMInstanceName=RLC_Series:1521 EnableC=false EnableL=false R=0ohm)
  U1522 = RLC_Series(EMInstanceName=RLC_Series:1522 EnableL=false R=0ohm EnableR=true EnableC=false)
  U1523 = RLC_Series(EMInstanceName=RLC_Series:1523 EnableL=false EnableC=false R=0ohm)
  U1524 = RLC_Series(EMInstanceName=RLC_Series:1524 EnableC=false EnableL=false R=0ohm EnableR=true)
  U1525 = RLC_Series(EMInstanceName=RLC_Series:1525 EnableL=false EnableC=false R=0ohm)
  U1526 = RLC_Series(EMInstanceName=RLC_Series:1526 R=0ohm EnableR=true EnableL=false EnableC=false)
  U1527 = RLC_Series(EMInstanceName=RLC_Series:1527 EnableL=false EnableC=false R=0ohm)
  U1529 = RLC_Series(EMInstanceName=RLC_Series:1529 R=0ohm EnableR=true EnableL=false EnableC=false)
  U1530 = RLC_Series(EMInstanceName=RLC_Series:1530 EnableC=false EnableL=false R=0ohm)
  U1531 = RLC_Series(EMInstanceName=RLC_Series:1531 R=0ohm EnableR=true EnableL=false EnableC=false)
nets:
  InternalPort1: U1508.1
  InternalPort10: U1512.1
  InternalPort11: U1513.0
  InternalPort12: U1513.1
  InternalPort13: U1514.0
  InternalPort14: U1514.1
  InternalPort15: U1515.0
  InternalPort16: U1515.1
  InternalPort17: U1516.0
  InternalPort18: U1516.1
  InternalPort19: U1517.0
  InternalPort2: U1508.0
  InternalPort20: U1517.1
  InternalPort21: U1518.0
  InternalPort22: U1518.1
  InternalPort23: U1519.0
  InternalPort24: U1519.1
  InternalPort25: U1520.0
  InternalPort26: U1520.1
  InternalPort27: U1521.0
  InternalPort28: U1521.1
  InternalPort29: U1522.0
  InternalPort3: U1509.0
  InternalPort30: U1522.1
  InternalPort31: U1523.0
  InternalPort32: U1523.1
  InternalPort33: U1524.0
  InternalPort34: U1524.1
  InternalPort35: U1525.0
  InternalPort36: U1525.1
  InternalPort37: U1526.0
  InternalPort38: U1526.1
  InternalPort39: U1527.0
  InternalPort4: U1509.1
  InternalPort40: U1527.1
  InternalPort41: U1529.0
  InternalPort42: U1529.1
  InternalPort43: U1530.0
  InternalPort44: U1530.1
  InternalPort45: U1531.0
  InternalPort46: U1531.1
  InternalPort5: U1510.0
  InternalPort6: U1510.1
  InternalPort7: U1511.0
  InternalPort8: U1511.1
  InternalPort9: U1512.0
ports:
  Port1, Port2: Properties{Reference=Ground Impedance=50ohm Magnitude=1V Phase=0deg Renormalize_Impedence="50ohm + 0i ohm" Renormalize Deembed_Distance=0mm Deembed Type="Single Strip Gap Source" HFSS_Type=Gap Orientation=Vertical Layer_Alignment=Upper Horizontal_Extent_Factor=5 Vertical_Extent_Factor=3 PEC_Launch_Width=0.1mm} Type=EdgePort
EM properties:
  rect_2878 EM props: Type(ThinFilm) Properties{SheetImpedance="166ohm + 0i ohm" Model_as_Sheet} Element=rect_2878
  rect_2879 EM props: Type(ThinFilm) Properties{SheetImpedance="164ohm + 0i ohm" Model_as_Sheet} Element=rect_2879
  rect_2880 EM props: Type(ThinFilm) Properties{SheetImpedance="152ohm + 0i ohm" Model_as_Sheet} Element=rect_2880
  rect_2881 EM props: Type(ThinFilm) Properties{SheetImpedance="140ohm + 0i ohm" Model_as_Sheet} Element=rect_2881
  rect_2882 EM props: Type(ThinFilm) Properties{SheetImpedance="130ohm + 0i ohm" Model_as_Sheet} Element=rect_2882
  rect_2883 EM props: Type(ThinFilm) Properties{SheetImpedance="120ohm + 0i ohm" Model_as_Sheet} Element=rect_2883
  rect_2884 EM props: Type(ThinFilm) Properties{SheetImpedance="102ohm + 0i ohm" Model_as_Sheet} Element=rect_2884
setups:
  PlanarEM Setup 1: SolveSetupType=PEM PercentRefinementPerPass=25 MinNumberOfPasses=1 MinNumberOfConvergedPasses=1 Frequency=10GHz MeshSizeFactor=10 ViaNumSides=1 ViaMaterial=copper Style25DVia=Wirebond
    sweep Sweep 1: LIN 100MHz 15GHz 0.25GHz; SAbsError=0.005 ZoPercentError=1 PassivityTolerance=0.0001 MaxSolutions=250 InterpUseSMatrix InterpUsePortImpedance InterpUseFullBasis MagMinThreshold=0.01
reports:
  S Parameter Plot 1: dB(S(Port1,Port1)), dB(S(Port2,Port1)) vs F on PlanarEM Setup 1 : Sweep 1

design Simsetup (HFSS 3D Layout)
variables:
  C = 0.5mm  # tune 0.3mm..0.9mm
  D = 0.2mm  # tune 0.15mm..0.45mm
  A = 5mm
components:
  U1558 = RLC_Series(EMInstanceName=RLC_Series:1558 EnableC=false EnableL=false R=0ohm)
  S1566 = PMA2-153LN+_5(EMInstanceName=PMA2-153LN+_5:1566)
nets:
  InternalPort1: U1558.0
  InternalPort2: U1558.1
  InternalPort3: S1566.0
  InternalPort4: S1566.1
ports:
  Port1, Port2: Properties{Reference=Ground Impedance=50ohm Magnitude=1V Phase=0deg Renormalize_Impedence="50ohm + 0i ohm" Renormalize Deembed_Distance=0mm Deembed Type="Single Strip Gap Source" HFSS_Type=Gap Orientation=Vertical Layer_Alignment=Upper Horizontal_Extent_Factor=5 Vertical_Extent_Factor=3 PEC_Launch_Width=0.1mm} Type=EdgePort
setups:
  PlanarEM Setup 1: SolveSetupType=PEM PercentRefinementPerPass=30 MinNumberOfPasses=1 MinNumberOfConvergedPasses=1 Frequency=6.6GHz MeshSizeFactor=10 ViaNumSides=1 ViaMaterial=copper Style25DVia=Mesh
    sweep Sweep 1: LIN 100MHz 15GHz 0.25GHz; SAbsError=0.005 ZoPercentError=1 PassivityTolerance=0.0001 MaxSolutions=250 InterpUseSMatrix InterpUsePortImpedance InterpUseFullBasis MagMinThreshold=0.01
reports:
  S Parameter Plot 1: dB(S(Port1,Port1)), dB(S(Port2,Port1)) vs F on PlanarEM Setup 1 : Sweep 1

design Attenuator Simulation (HFSS 3D Layout)
variables:
  C = 0.5mm  # tune 0.3mm..0.9mm
  D = 0.2mm  # tune 0.15mm..0.45mm
  A = 5mm
components:
  S1589 = HMC 424 ALP3E(EMInstanceName="HMC 424 ALP3E:1589")
ports:
  Port1, Port2: Properties{Reference=Ground Impedance=50ohm Magnitude=1V Phase=0deg Renormalize_Impedence="50ohm + 0i ohm" Renormalize Deembed_Distance=0mm Deembed Type="Single Strip Gap Source" HFSS_Type=Gap Orientation=Vertical Layer_Alignment=Upper Horizontal_Extent_Factor=5 Vertical_Extent_Factor=3 PEC_Launch_Width=0.1mm} Type=EdgePort
setups:
  PlanarEM Setup 1: SolveSetupType=PEM PercentRefinementPerPass=30 MinNumberOfPasses=1 MinNumberOfConvergedPasses=1 Frequency=12GHz MeshSizeFactor=10 ViaNumSides=1 ViaMaterial=copper Style25DVia=Mesh
    sweep Sweep 1: LIN 100MHz 15GHz 0.05GHz; SAbsError=0.005 ZoPercentError=1 PassivityTolerance=0.0001 MaxSolutions=250 InterpUseSMatrix InterpUsePortImpedance InterpUseFullBasis MagMinThreshold=0.01
reports:
  S Parameter Plot 1: dB(S(Port1,Port1)), dB(S(Port2,Port1)) vs F on PlanarEM Setup 1 : Sweep 1

design PMA2 HMC424 Sim1 (HFSS 3D Layout)
variables:
  C = 0.5mm  # tune 0.3mm..0.9mm
  D = 0.2mm  # tune 0.15mm..0.45mm
  A = 5mm
components:
  S1589 = HMC 424 ALP3E(EMInstanceName="HMC 424 ALP3E:1635")
  U1587 = RLC_Series(EMInstanceName=RLC_Series:1636 EnableL=false EnableR=false C=0.1uF)
  U1585 = RLC_Series(EMInstanceName=RLC_Series:1637 EnableR=false EnableL=false C=0.1uF)
  S1618 = AEQ5471(EMInstanceName=AEQ5471:1638)
  S1586 = PMA2-153LN+_6(EMInstanceName=PMA2-153LN+_6:1639)
ports:
  Port1, Port2: Properties{Reference=Ground Impedance=50ohm Magnitude=1V Phase=0deg Renormalize_Impedence="50ohm + 0i ohm" Renormalize Deembed_Distance=0mm Deembed Type="Single Strip Gap Source" HFSS_Type=Gap Orientation=Vertical Layer_Alignment=Upper Horizontal_Extent_Factor=5 Vertical_Extent_Factor=3 PEC_Launch_Width=0.1mm} Type=EdgePort
setups:
  PlanarEM Setup 1: SolveSetupType=PEM PercentRefinementPerPass=30 MinNumberOfPasses=1 MinNumberOfConvergedPasses=1 Frequency=6.6GHz MeshSizeFactor=10 ViaNumSides=1 ViaMaterial=copper Style25DVia=Mesh
    sweep Sweep 1: LIN 100MHz 15GHz 0.05GHz; SAbsError=0.005 ZoPercentError=1 PassivityTolerance=0.0001 MaxSolutions=250 InterpUseSMatrix InterpUsePortImpedance InterpUseFullBasis MagMinThreshold=0.01
reports:
  S Parameter Plot 1: dB(S(Port1,Port1)), dB(S(Port2,Port1)) vs F on PlanarEM Setup 1 : Sweep 1

design Amplifier Simulation (HFSS 3D Layout)
variables:
  C = 0.5mm  # tune 0.3mm..0.9mm
  D = 0.2mm  # tune 0.15mm..0.45mm
  A = 5mm
components:
  U1585 = RLC_Series(EMInstanceName=RLC_Series:1585 EnableR=false EnableL=false C=0.1uF)
  U1587 = RLC_Series(EMInstanceName=RLC_Series:1587 EnableL=false EnableR=false C=0.1uF)
  S1618 = AEQ5471(EMInstanceName=AEQ5471:1618)
  S1815 = PMA2-153LN+_MIN45(EMInstanceName=PMA2-153LN+_MIN45:1815)
nets:
  InternalPort1: U1585.0
  InternalPort2: U1585.1
  InternalPort3: S1815.Port1
  InternalPort4: S1815.Port2
  InternalPort5: U1587.0
  InternalPort6: U1587.1
ports:
  Port1, Port2: Properties{Reference=Ground Impedance=50ohm Magnitude=1V Phase=0deg Renormalize_Impedence="50ohm + 0i ohm" Renormalize Deembed_Distance=0mm Deembed Type="Single Strip Gap Source" HFSS_Type=Gap Orientation=Vertical Layer_Alignment=Upper Horizontal_Extent_Factor=5 Vertical_Extent_Factor=3 PEC_Launch_Width=0.1mm} Type=EdgePort
setups:
  PlanarEM Setup 1: SolveSetupType=PEM PercentRefinementPerPass=30 MinNumberOfPasses=1 MinNumberOfConvergedPasses=1 Frequency=12GHz MeshSizeFactor=10 ViaNumSides=1 ViaMaterial=copper Style25DVia=Mesh
    sweep Sweep 1: LIN 100MHz 15GHz 0.05GHz; SAbsError=0.005 ZoPercentError=1 PassivityTolerance=0.0001 MaxSolutions=250 InterpUseSMatrix InterpUsePortImpedance InterpUseFullBasis MagMinThreshold=0.01
reports:
  S Parameter Plot 1: dB(S(Port1,Port1)), dB(S(Port2,Port1)) vs F on PlanarEM Setup 1 : Sweep 1
