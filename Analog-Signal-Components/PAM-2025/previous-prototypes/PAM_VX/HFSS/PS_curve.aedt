# Ansys Electronics Desktop project, version 2023.2
project variables:
  $w_lin = 0.53789169mm
  $w_gnd_top = 2mm  # optimise 2.5mm..7.5mm
  $d = 0.11434763mm
materials:
  vacuum: permittivity=1
  FR4_epoxy: permittivity=4.4 dielectric_loss_tangent=0.02
  air: permittivity=1.0006 permeability=1.0000004
  rhodium: conductivity=22200000
  Rogers RO4350 (tm): permittivity=3.66 dielectric_loss_tangent=0.004
  copper: permeability=0.999991 conductivity=58000000

design HFSSDesign2 (HFSS, HFSS Modal Network, model units mm)
variables:
  w = 15mm
  l = 15mm
  h_sub = 0.508mm
  h_gnd3 = 0.03556mm
  w_lin = 1.04mm
  h_sig = 0.03556mm
  w_gnd_top = 3mm
  h_ges = h_gnd3+h_sig+h_sub
  pos_gnd1 = w/2-$w_lin/2-$d-w_gnd_top
  pos_lin = w/2-$w_lin/2
  pos_gnd2 = w/2+$w_lin/2+$d
geometry:
  line = box(corner=(pos_lin, 15mm, h_gnd3+h_sub), size=($w_lin, 2.51mm, h_sig))
  gnd_top_end [copper] = box(corner=(pos_lin-$d-$w_gnd_top, 15mm, h_gnd3+h_sub), size=($w_gnd_top, 2.51mm, h_sig))
  gnd2_top = box(corner=(pos_gnd2, 15mm, h_gnd3+h_sub), size=($w_gnd_top, 2.51mm, h_sig))
  port1 = rectangle(corner=(w/2-$d*5, 0mm, 0mm), z_size=h_ges*4, x_size=$d*10)
  port2 = rectangle(corner=(w/2-$d*5, l, 0mm), z_size=h_ges*4, x_size=$d*10)
  gnd_top_end.unite(gnd2_top)
  via1 = cylinder(axis=Z, base_centre=(23.32mm, 2mm, h_gnd3), radius=0.2mm, height=h_sub)
  via1_0 [copper] = via1.duplicate_along_line(step=(0mm, 2.4mm, 0mm), total=300)  # copies kept: 2
  sub [Rogers RO4350 (tm)] = polyline(z=0.03556mm, xy in mm: (0, 0) (8, 0) (8, 5.75) (15, 5.75) (15, 15) (0, 15) (0, 0), closed, covered)
  sub.thicken(h_sub)
  gnd_bot [copper] = polyline(z=0mm, xy in mm: (0, 0) (8, 0) (8, 5.75) (15, 5.75) (15, 15) (0, 15) (0, 0), closed, covered)
  gnd_bot.thicken(h_gnd3)
  gnd_top_end.unite(line)
  gnd1_top1 = box(corner=(pos_lin-$d-$w_gnd_top, 15mm, h_gnd3+h_sub), size=($w_gnd_top, -l, h_sig))
  gnd2_top1 = box(corner=(pos_gnd2, 15mm, h_gnd3+h_sub), size=($w_gnd_top, -l, h_sig))
  gnd1_top1.unite(gnd2_top1)
  line1 = box(corner=(pos_lin, 15mm, h_gnd3+h_sub), size=($w_lin, -l, h_sig))
  gnd1_top1.unite(line1)
  gnd1_top1.rotate(axis=Z, angle=90deg)
  gnd1_top1.move(23mm, -5.1167065mm, -1.110223e-16mm)
  gnd1_top1.move(0mm, 0.75mm, 0mm)
  line1_3 = object_from(gnd1_top1.face(5 of 6))
  coordinate_system Curve1_Axis = origin=(8mm, 6.25mm, 0mm) x=(1mm, 0mm, 0mm) y=(0mm, 1mm, 0mm)
  line1_3.sweep_around_axis(axis=Z, angle=180deg) in Curve1_Axis
  line1_3.mirror(point=(0mm, -3.3856524mm, 0.57912mm), normal=(1mm, -8.8817842e-17mm, 0mm)) in Curve1_Axis
  line2 = object_from(gnd_top_end.face(#5371))
  coordinate_system Curve2_Axis = origin=(0mm, 6.24mm, 0mm) x=(1mm, 0mm, 0mm) y=(0mm, 1mm, 0mm) in Curve1_Axis
  line2.sweep_around_axis(axis=Z, angle=90deg) in Curve2_Axis
  gnd_top_end.move(3.6232935mm, -2.51mm, -1.110223e-16mm) in Curve2_Axis
  gnd2_top1_1 = object_from(gnd1_top1.face(5 of 6))
  gnd2_top1_1.sweep_around_axis(axis=Z, angle=-180deg) in Curve1_Axis
  gnd1_top1_3 = object_from(gnd1_top1.face(5 of 6))
  gnd1_top1.delete()
  gnd1_top1_3.sweep_around_axis(axis=Z, angle=-180deg) in Curve1_Axis
  gnd2_top2 = object_from(gnd_top_end.face(#5456))
  gnd2_top2.sweep_around_axis(axis=Z, angle=90deg) in Curve2_Axis
  gnd1_top2 = object_from(gnd_top_end.face(#5486))
  gnd1_top2.sweep_around_axis(axis=Z, angle=90deg) in Curve2_Axis
  via1.move(-13.58mm, 8.2mm, 1.110223e-16mm) in Curve2_Axis
  via1.delete()
  via1_0.move(-13.58mm, 8.2mm, 1.110223e-16mm) in Curve2_Axis
  via1_0.move(0mm, -1.255mm, 0mm) in Curve2_Axis
  via2 = cylinder(axis=Z, base_centre=(23.32mm, 2mm, h_gnd3), radius=0.2mm, height=h_sub)
  via1_01 [copper] = via2.duplicate_along_line(step=(0mm, 2.4mm, 0mm), total=300)  # copies kept: 2
  via2.delete()
  coordinate_system RelativeCS3 = origin=(8mm, 6.25mm, 0mm) x=(1mm, 0mm, 0mm) y=(0mm, 1mm, 0mm)
  coordinate_system RelativeCS4 = origin=(0mm, 6.24mm, 0mm) x=(1mm, 0mm, 0mm) y=(0mm, 1mm, 0mm) in RelativeCS3
  via1_01.move(-13.58mm, 8.2mm, 1.110223e-16mm) in RelativeCS4
  via1_01.move(0mm, -1.255mm, 0mm) in RelativeCS4
  via1_01.move(0mm, -1.255mm, 0mm)
  via1_01_1, via1_01_2 [copper] = via1_01.duplicate_around_axis(axis=Z, angle=-45deg, total=3) in Curve2_Axis
  via1_01_2_1..via1_01_2_9 [copper] = via1_01_2.duplicate_around_axis(axis=Z, angle=19deg, total=10) in Curve1_Axis
  via3 = cylinder(axis=Z, base_centre=(23.32mm, 2mm, h_gnd3), radius=0.2mm, height=h_sub)
  via1_02 [copper] = via3.duplicate_along_line(step=(0mm, 2.4mm, 0mm), total=300)  # copies kept: 2
  via3.delete()
  coordinate_system Curve1_Axis1 = origin=(8mm, 6.25mm, 0mm) x=(1mm, 0mm, 0mm) y=(0mm, 1mm, 0mm)
  coordinate_system Curve2_Axis1 = origin=(0mm, 6.24mm, 0mm) x=(1mm, 0mm, 0mm) y=(0mm, 1mm, 0mm) in Curve1_Axis1
  via1_02.move(-13.58mm, 8.2mm, 1.110223e-16mm) in Curve2_Axis1
  via1_02.move(0mm, -1.255mm, 0mm) in Curve2_Axis1
  via1_02.move(2.766587mm, 0mm, 0mm)
  via4 = cylinder(axis=Z, base_centre=(23.32mm, 2mm, h_gnd3), radius=0.2mm, height=h_sub)
  via1_03 [copper] = via4.duplicate_along_line(step=(0mm, 2.4mm, 0mm), total=300)  # copies kept: 2
  via4.delete()
  coordinate_system Curve1_Axis2 = origin=(8mm, 6.25mm, 0mm) x=(1mm, 0mm, 0mm) y=(0mm, 1mm, 0mm)
  coordinate_system Curve2_Axis2 = origin=(0mm, 6.24mm, 0mm) x=(1mm, 0mm, 0mm) y=(0mm, 1mm, 0mm) in Curve1_Axis2
  via1_03.move(-13.58mm, 8.2mm, 1.110223e-16mm) in Curve2_Axis2
  via1_03.move(0mm, -1.255mm, 0mm) in Curve2_Axis2
  via1_03.move(2.766587mm, 0mm, 0mm)
  via1_03.move(0mm, -1.255mm, 0mm)
  via1_03_1..via1_03_5 [copper] = via1_03.duplicate_around_axis(axis=Z, angle=-18deg, total=6) in Curve2_Axis2
  via1_03_5_1, via1_03_5_2, via1_03_5_3 [copper] = via1_03_5.duplicate_around_axis(axis=Z, angle=50deg, total=4) in Curve1_Axis
  gnd_top_end.unite(gnd1_top1_3, gnd1_top2, gnd2_top1_1, gnd2_top2, line1_3, line2)
  port1.rotate(axis=Z, angle=90deg)
  port2.move(6.9282618mm, 0mm, 0mm)
  port2.move(-3.3049684mm, 0mm, 0mm)
  port1.move(8mm, -6.9282618mm, 0mm)
  port1.move(0mm, 2.55826185mm, 0mm)
  radbox [air] = polyline(z=-15mm, xy in mm: (-5, -5) (8, -5) (8, 3.75) (20, 3.75) (20, 15) (-5, 15) (-5, -5), closed, covered)
  radbox.thicken(h_ges+30mm)
boundaries and excitations:
  Rad1: Radiation Objects=radbox
  1: Wave Port Objects=port1 WavePortType=Modal NumModes=1 Modes{Mode1{CharImp=Zpi RenormImp=50ohm}}
  2: Wave Port Objects=port2 WavePortType=Modal NumModes=1 Modes{Mode1{CharImp=Zpi RenormImp=50ohm}}
setups:
  Setup1: HfssDriven Frequency=10GHz MaxDeltaS=0.02 MaximumPasses=20 MinimumPasses=1 MinimumConvergedPasses=1 PercentRefinement=30 BasisOrder=1 PortAccuracy=2 DrivenSolverType="Direct Solver"
    sweep Sweep_fast: 10GHz to 20GHz step 0.3GHz; Type=Discrete
    sweep Sweep: 1GHz to 20GHz step 0.1GHz; Type=Discrete
source amplitudes:
  1:1: 1W 0deg
  2:1: 0W 0deg
optimetrics:
  OptimizationSetup1: Optimization Optimizer="kDX ASO" AnalysisStopOptions{StopForNumIteration MaxNumIteration=20 MinNumIteration=10} CostFuncNormType=L2 Acceptable_Cost=0 Noise=0.0001 UpdateDesignWhenDone
    vary $w_gnd_top: Min=1.6mm Max=5mm MinStep=0.05mm MaxStep=0.5mm MinFocus=2.5mm MaxFocus=7.5mm start=2mm
    goal dB(S(1,1)) <= -30 weight 1 on Setup1 : Sweep_fast at Freq 10GHz to 19.9GHz
field plots:
  E_Sub: E Field in sub on Setup1 : LastAdaptive at Freq=10GHz Phase=0deg
  E_Sig: E Field over gnd_top_end.face(all 30) on Setup1 : LastAdaptive at Freq=10GHz Phase=0deg
reports:
  Port Zo Plot 1: mag(Zo(1)), mag(Zo(2)) vs Freq on Setup1 : Sweep [w_gnd_top=all]
  S Parameter Plot 1: dB(S(1,1)), dB(S(2,1)), dB(S(1,2)), dB(S(2,2)) vs Freq on Setup1 : Sweep; markers m1 at 6.2GHz, m2 at 18.6GHz
